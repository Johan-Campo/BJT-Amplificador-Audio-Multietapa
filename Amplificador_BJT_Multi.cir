* Amplificador Multietapa BJT

VCC Vcc 0 DC 24
Vin In 0 AC 1 SIN(0 0.01 500)

***********************
* ETAPA 1 (EMISOR COMUN)
***********************

R13 In N1 50k
C1 N1 B1 1000u

R2 Vcc B1 180k
R1 B1 0 22k

R9 Vcc C1N 12k
R8 E1 0 1k
C5 E1 0 470u

Q1 C1N B1 E1 2N3904

***********************
* ETAPA 2 (EMISOR COMUN)
***********************

C2 C1N B2 1000u

R3 Vcc B2 78.7k
R4 B2 0 12k

R11 Vcc C2N 10k

R10 E2 0 470
C6 E2 0 470u

Q2 C2N B2 E2 2N3904

***********************
* ETAPA 3 (BUFFER)
***********************

C3 C2N B3 1000u

R5 Vcc B3 15k
R6 B3 0 15k

Q3 Vcc B3 N3 TIP41C

***********************
* ETAPA 4 (POTENCIA)
***********************

Q4 Vcc N3 E4 TIP41C

R7 E4 0 47

***********************
* SALIDA
***********************

C4 E4 OUT 9400u
R12 OUT 0 4

***********************
* MODELOS
***********************

.model 2N3904 NPN
.model TIP41C NPN

.op
*.ac dec 100 1 1Meg

*.tran 0 100m

.end
